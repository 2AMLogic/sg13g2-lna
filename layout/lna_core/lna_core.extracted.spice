* extracted by klt extract --deck sg13g2

* cell lna_core
* pin b1
* pin bref
* pin cb3
* pin dn
* pin e1,vss
* pin es
* pin gsvo
* pin nca
* pin ncb
* pin nce
* pin outn,vdd
* pin rfin,xin
* pin rfout
* pin vb2
* pin vbg
* pin vl
* pin xout
* pin casc
.SUBCKT lna_core b1 bref cb3 dn e1|vss es gsvo nca ncb nce outn|vdd rfin|xin
+ rfout vb2 vbg vl xout casc
* device instance $1 r0 *1 -959.16,105 nfet
M$1 gsvo vbg es e1|vss nfet L=1U W=10U AS=3.4P AD=3.4P PS=20.68U PD=20.68U
* device instance $2 r0 *1 -953.16,105 nfet
M$2 dn vl es e1|vss nfet L=1U W=10U AS=3.4P AD=3.4P PS=20.68U PD=20.68U
* device instance $3 r0 *1 -69.16,18 pfet
M$3 bref gsvo outn|vdd outn|vdd pfet L=1U W=16U AS=5.44P AD=3.04P PS=32.68U
+ PD=16.38U
* device instance $4 r0 *1 -67.78,18 pfet
M$4 outn|vdd gsvo bref outn|vdd pfet L=1U W=16U AS=3.04P AD=3.04P PS=16.38U
+ PD=16.38U
* device instance $5 r0 *1 -66.4,18 pfet
M$5 bref gsvo outn|vdd outn|vdd pfet L=1U W=16U AS=3.04P AD=3.04P PS=16.38U
+ PD=16.38U
* device instance $6 r0 *1 -65.02,18 pfet
M$6 outn|vdd gsvo bref outn|vdd pfet L=1U W=16U AS=3.04P AD=3.04P PS=16.38U
+ PD=16.38U
* device instance $7 r0 *1 -63.64,18 pfet
M$7 bref gsvo outn|vdd outn|vdd pfet L=1U W=16U AS=3.04P AD=3.04P PS=16.38U
+ PD=16.38U
* device instance $8 r0 *1 -62.26,18 pfet
M$8 outn|vdd gsvo bref outn|vdd pfet L=1U W=16U AS=3.04P AD=3.04P PS=16.38U
+ PD=16.38U
* device instance $9 r0 *1 -60.88,18 pfet
M$9 bref gsvo outn|vdd outn|vdd pfet L=1U W=16U AS=3.04P AD=3.04P PS=16.38U
+ PD=16.38U
* device instance $10 r0 *1 -59.5,18 pfet
M$10 outn|vdd gsvo bref outn|vdd pfet L=1U W=16U AS=3.04P AD=3.04P PS=16.38U
+ PD=16.38U
* device instance $11 r0 *1 -58.12,18 pfet
M$11 bref gsvo outn|vdd outn|vdd pfet L=1U W=16U AS=3.04P AD=3.04P PS=16.38U
+ PD=16.38U
* device instance $12 r0 *1 -56.74,18 pfet
M$12 outn|vdd gsvo bref outn|vdd pfet L=1U W=16U AS=3.04P AD=3.04P PS=16.38U
+ PD=16.38U
* device instance $13 r0 *1 -55.36,18 pfet
M$13 bref gsvo outn|vdd outn|vdd pfet L=1U W=16U AS=3.04P AD=3.04P PS=16.38U
+ PD=16.38U
* device instance $14 r0 *1 -53.98,18 pfet
M$14 outn|vdd gsvo bref outn|vdd pfet L=1U W=16U AS=3.04P AD=3.04P PS=16.38U
+ PD=16.38U
* device instance $15 r0 *1 -52.6,18 pfet
M$15 bref gsvo outn|vdd outn|vdd pfet L=1U W=16U AS=3.04P AD=3.04P PS=16.38U
+ PD=16.38U
* device instance $16 r0 *1 -51.22,18 pfet
M$16 outn|vdd gsvo bref outn|vdd pfet L=1U W=16U AS=3.04P AD=3.04P PS=16.38U
+ PD=16.38U
* device instance $17 r0 *1 -49.84,18 pfet
M$17 bref gsvo outn|vdd outn|vdd pfet L=1U W=16U AS=3.04P AD=3.04P PS=16.38U
+ PD=16.38U
* device instance $18 r0 *1 -48.46,18 pfet
M$18 outn|vdd gsvo bref outn|vdd pfet L=1U W=16U AS=3.04P AD=3.04P PS=16.38U
+ PD=16.38U
* device instance $19 r0 *1 -47.08,18 pfet
M$19 bref gsvo outn|vdd outn|vdd pfet L=1U W=16U AS=3.04P AD=3.04P PS=16.38U
+ PD=16.38U
* device instance $20 r0 *1 -45.7,18 pfet
M$20 outn|vdd gsvo bref outn|vdd pfet L=1U W=16U AS=3.04P AD=3.04P PS=16.38U
+ PD=16.38U
* device instance $21 r0 *1 -44.32,18 pfet
M$21 bref gsvo outn|vdd outn|vdd pfet L=1U W=16U AS=3.04P AD=3.04P PS=16.38U
+ PD=16.38U
* device instance $22 r0 *1 -42.94,18 pfet
M$22 outn|vdd gsvo bref outn|vdd pfet L=1U W=16U AS=3.04P AD=3.04P PS=16.38U
+ PD=16.38U
* device instance $23 r0 *1 -41.56,18 pfet
M$23 bref gsvo outn|vdd outn|vdd pfet L=1U W=16U AS=3.04P AD=3.04P PS=16.38U
+ PD=16.38U
* device instance $24 r0 *1 -40.18,18 pfet
M$24 outn|vdd gsvo bref outn|vdd pfet L=1U W=16U AS=3.04P AD=3.04P PS=16.38U
+ PD=16.38U
* device instance $25 r0 *1 -38.8,18 pfet
M$25 bref gsvo outn|vdd outn|vdd pfet L=1U W=16U AS=3.04P AD=3.04P PS=16.38U
+ PD=16.38U
* device instance $26 r0 *1 -37.42,18 pfet
M$26 outn|vdd gsvo bref outn|vdd pfet L=1U W=16U AS=3.04P AD=3.04P PS=16.38U
+ PD=16.38U
* device instance $27 r0 *1 -36.04,18 pfet
M$27 bref gsvo outn|vdd outn|vdd pfet L=1U W=16U AS=3.04P AD=3.04P PS=16.38U
+ PD=16.38U
* device instance $28 r0 *1 -34.66,18 pfet
M$28 outn|vdd gsvo bref outn|vdd pfet L=1U W=16U AS=3.04P AD=3.04P PS=16.38U
+ PD=16.38U
* device instance $29 r0 *1 -33.28,18 pfet
M$29 bref gsvo outn|vdd outn|vdd pfet L=1U W=16U AS=3.04P AD=3.04P PS=16.38U
+ PD=16.38U
* device instance $30 r0 *1 -31.9,18 pfet
M$30 outn|vdd gsvo bref outn|vdd pfet L=1U W=16U AS=3.04P AD=3.04P PS=16.38U
+ PD=16.38U
* device instance $31 r0 *1 -30.52,18 pfet
M$31 bref gsvo outn|vdd outn|vdd pfet L=1U W=16U AS=3.04P AD=3.04P PS=16.38U
+ PD=16.38U
* device instance $32 r0 *1 -29.14,18 pfet
M$32 outn|vdd gsvo bref outn|vdd pfet L=1U W=16U AS=3.04P AD=3.04P PS=16.38U
+ PD=16.38U
* device instance $33 r0 *1 -27.76,18 pfet
M$33 bref gsvo outn|vdd outn|vdd pfet L=1U W=16U AS=3.04P AD=3.04P PS=16.38U
+ PD=16.38U
* device instance $34 r0 *1 -26.38,18 pfet
M$34 outn|vdd gsvo bref outn|vdd pfet L=1U W=16U AS=3.04P AD=5.44P PS=16.38U
+ PD=32.68U
* device instance $35 r0 *1 -999.16,105 pfet
M$35 ncb ncb outn|vdd outn|vdd pfet L=1U W=10U AS=3.4P AD=3.4P PS=20.68U
+ PD=20.68U
* device instance $36 r0 *1 -993.16,105 pfet
M$36 nca ncb outn|vdd outn|vdd pfet L=1U W=10U AS=3.4P AD=3.4P PS=20.68U
+ PD=20.68U
* device instance $37 r0 *1 -987.16,105 pfet
M$37 vbg ncb outn|vdd outn|vdd pfet L=1U W=10U AS=3.4P AD=3.4P PS=20.68U
+ PD=20.68U
* device instance $38 r0 *1 -981.16,105 pfet
M$38 dn dn outn|vdd outn|vdd pfet L=1U W=10U AS=3.4P AD=3.4P PS=20.68U PD=20.68U
* device instance $39 r0 *1 -975.16,105 pfet
M$39 gsvo dn outn|vdd outn|vdd pfet L=1U W=10U AS=3.4P AD=3.4P PS=20.68U
+ PD=20.68U
* device instance $40 r0 *1 -969.16,120 pfet
M$40 vl gsvo outn|vdd outn|vdd pfet L=1U W=40U AS=13.6P AD=13.6P PS=80.68U
+ PD=80.68U
* device instance $41 r0 *1 180.187,-319.813 cap_cmim
C$41 e1|vss rfin|xin 6.259709375e-13
* device instance $42 r0 *1 239.14,-320.86 cap_cmim
C$42 e1|vss xout 5.041624e-13
* device instance $43 r0 *1 297.572,-322.428 cap_cmim
C$43 rfout xout 3.464797375e-13
* device instance $44 r0 *1 -967.75,-245.75 cap_cmim
C$44 e1|vss vb2 6.250695e-12
* device instance $45 r0 *1 -901.25,-245.75 cap_cmim
C$45 e1|vss vb2 6.250695e-12
* device instance $46 r0 *1 -834.75,-245.75 cap_cmim
C$46 e1|vss vb2 6.250695e-12
* device instance $47 r0 *1 -768.25,-245.75 cap_cmim
C$47 e1|vss vb2 6.250695e-12
* device instance $48 r0 *1 -967.75,-179.25 cap_cmim
C$48 e1|vss vb2 6.250695e-12
* device instance $49 r0 *1 -901.25,-179.25 cap_cmim
C$49 e1|vss vb2 6.250695e-12
* device instance $50 r0 *1 -834.75,-179.25 cap_cmim
C$50 e1|vss vb2 6.250695e-12
* device instance $51 r0 *1 -768.25,-179.25 cap_cmim
C$51 e1|vss vb2 6.250695e-12
* device instance $52 r0 *1 -967.75,-112.75 cap_cmim
C$52 e1|vss vb2 6.250695e-12
* device instance $53 r0 *1 -901.25,-112.75 cap_cmim
C$53 e1|vss vb2 6.250695e-12
* device instance $54 r0 *1 -834.75,-112.75 cap_cmim
C$54 e1|vss vb2 6.250695e-12
* device instance $55 r0 *1 -768.25,-112.75 cap_cmim
C$55 e1|vss vb2 6.250695e-12
* device instance $56 r0 *1 -967.75,-46.25 cap_cmim
C$56 e1|vss vb2 6.250695e-12
* device instance $57 r0 *1 -901.25,-46.25 cap_cmim
C$57 e1|vss vb2 6.250695e-12
* device instance $58 r0 *1 -834.75,-46.25 cap_cmim
C$58 e1|vss vb2 6.250695e-12
* device instance $59 r0 *1 -768.25,-46.25 cap_cmim
C$59 e1|vss vb2 6.250695e-12
* device instance $60 r0 *1 -667.75,-245.75 cap_cmim
C$60 e1|vss outn|vdd 6.250695e-12
* device instance $61 r0 *1 -601.25,-245.75 cap_cmim
C$61 e1|vss outn|vdd 6.250695e-12
* device instance $62 r0 *1 -534.75,-245.75 cap_cmim
C$62 e1|vss outn|vdd 6.250695e-12
* device instance $63 r0 *1 -468.25,-245.75 cap_cmim
C$63 e1|vss outn|vdd 6.250695e-12
* device instance $64 r0 *1 -667.75,-179.25 cap_cmim
C$64 e1|vss outn|vdd 6.250695e-12
* device instance $65 r0 *1 -601.25,-179.25 cap_cmim
C$65 e1|vss outn|vdd 6.250695e-12
* device instance $66 r0 *1 -534.75,-179.25 cap_cmim
C$66 e1|vss outn|vdd 6.250695e-12
* device instance $67 r0 *1 -468.25,-179.25 cap_cmim
C$67 e1|vss outn|vdd 6.250695e-12
* device instance $68 r0 *1 -667.75,-112.75 cap_cmim
C$68 e1|vss outn|vdd 6.250695e-12
* device instance $69 r0 *1 -601.25,-112.75 cap_cmim
C$69 e1|vss outn|vdd 6.250695e-12
* device instance $70 r0 *1 -534.75,-112.75 cap_cmim
C$70 e1|vss outn|vdd 6.250695e-12
* device instance $71 r0 *1 -468.25,-112.75 cap_cmim
C$71 e1|vss outn|vdd 6.250695e-12
* device instance $72 r0 *1 -667.75,-46.25 cap_cmim
C$72 e1|vss outn|vdd 6.250695e-12
* device instance $73 r0 *1 -601.25,-46.25 cap_cmim
C$73 e1|vss outn|vdd 6.250695e-12
* device instance $74 r0 *1 -534.75,-46.25 cap_cmim
C$74 e1|vss outn|vdd 6.250695e-12
* device instance $75 r0 *1 -468.25,-46.25 cap_cmim
C$75 e1|vss outn|vdd 6.250695e-12
* device instance $76 r0 *1 -107.75,-245.75 cap_cmim
C$76 e1|vss bref 6.250695e-12
* device instance $77 r0 *1 -41.25,-245.75 cap_cmim
C$77 e1|vss bref 6.250695e-12
* device instance $78 r0 *1 25.25,-245.75 cap_cmim
C$78 e1|vss bref 6.250695e-12
* device instance $79 r0 *1 91.75,-245.75 cap_cmim
C$79 e1|vss bref 6.250695e-12
* device instance $80 r0 *1 -107.75,-179.25 cap_cmim
C$80 e1|vss bref 6.250695e-12
* device instance $81 r0 *1 -41.25,-179.25 cap_cmim
C$81 e1|vss bref 6.250695e-12
* device instance $82 r0 *1 25.25,-179.25 cap_cmim
C$82 e1|vss bref 6.250695e-12
* device instance $83 r0 *1 91.75,-179.25 cap_cmim
C$83 e1|vss bref 6.250695e-12
* device instance $84 r0 *1 -107.75,-112.75 cap_cmim
C$84 e1|vss bref 6.250695e-12
* device instance $85 r0 *1 -41.25,-112.75 cap_cmim
C$85 e1|vss bref 6.250695e-12
* device instance $86 r0 *1 25.25,-112.75 cap_cmim
C$86 e1|vss bref 6.250695e-12
* device instance $87 r0 *1 91.75,-112.75 cap_cmim
C$87 e1|vss bref 6.250695e-12
* device instance $88 r0 *1 -107.75,-46.25 cap_cmim
C$88 e1|vss bref 6.250695e-12
* device instance $89 r0 *1 -41.25,-46.25 cap_cmim
C$89 e1|vss bref 6.250695e-12
* device instance $90 r0 *1 25.25,-46.25 cap_cmim
C$90 e1|vss bref 6.250695e-12
* device instance $91 r0 *1 91.75,-46.25 cap_cmim
C$91 e1|vss bref 6.250695e-12
* device instance $92 r0 *1 192.25,-245.75 cap_cmim
C$92 rfin|xin b1 6.250695e-12
* device instance $93 r0 *1 258.75,-245.75 cap_cmim
C$93 rfin|xin b1 6.250695e-12
* device instance $94 r0 *1 325.25,-245.75 cap_cmim
C$94 rfin|xin b1 6.250695e-12
* device instance $95 r0 *1 391.75,-245.75 cap_cmim
C$95 rfin|xin b1 6.250695e-12
* device instance $96 r0 *1 192.25,-179.25 cap_cmim
C$96 rfin|xin b1 6.250695e-12
* device instance $97 r0 *1 258.75,-179.25 cap_cmim
C$97 rfin|xin b1 6.250695e-12
* device instance $98 r0 *1 325.25,-179.25 cap_cmim
C$98 rfin|xin b1 6.250695e-12
* device instance $99 r0 *1 391.75,-179.25 cap_cmim
C$99 rfin|xin b1 6.250695e-12
* device instance $100 r0 *1 192.25,-112.75 cap_cmim
C$100 rfin|xin b1 6.250695e-12
* device instance $101 r0 *1 258.75,-112.75 cap_cmim
C$101 rfin|xin b1 6.250695e-12
* device instance $102 r0 *1 325.25,-112.75 cap_cmim
C$102 rfin|xin b1 6.250695e-12
* device instance $103 r0 *1 391.75,-112.75 cap_cmim
C$103 rfin|xin b1 6.250695e-12
* device instance $104 r0 *1 192.25,-46.25 cap_cmim
C$104 rfin|xin b1 6.250695e-12
* device instance $105 r0 *1 258.75,-46.25 cap_cmim
C$105 rfin|xin b1 6.250695e-12
* device instance $106 r0 *1 325.25,-46.25 cap_cmim
C$106 rfin|xin b1 6.250695e-12
* device instance $107 r0 *1 391.75,-46.25 cap_cmim
C$107 rfin|xin b1 6.250695e-12
* device instance $108 r0 *1 512.25,-245.75 cap_cmim
C$108 xout outn|vdd 6.250695e-12
* device instance $109 r0 *1 578.75,-245.75 cap_cmim
C$109 xout outn|vdd 6.250695e-12
* device instance $110 r0 *1 645.25,-245.75 cap_cmim
C$110 xout outn|vdd 6.250695e-12
* device instance $111 r0 *1 711.75,-245.75 cap_cmim
C$111 xout outn|vdd 6.250695e-12
* device instance $112 r0 *1 512.25,-179.25 cap_cmim
C$112 xout outn|vdd 6.250695e-12
* device instance $113 r0 *1 578.75,-179.25 cap_cmim
C$113 xout outn|vdd 6.250695e-12
* device instance $114 r0 *1 645.25,-179.25 cap_cmim
C$114 xout outn|vdd 6.250695e-12
* device instance $115 r0 *1 711.75,-179.25 cap_cmim
C$115 xout outn|vdd 6.250695e-12
* device instance $116 r0 *1 512.25,-112.75 cap_cmim
C$116 xout outn|vdd 6.250695e-12
* device instance $117 r0 *1 578.75,-112.75 cap_cmim
C$117 xout outn|vdd 6.250695e-12
* device instance $118 r0 *1 645.25,-112.75 cap_cmim
C$118 xout outn|vdd 6.250695e-12
* device instance $119 r0 *1 711.75,-112.75 cap_cmim
C$119 xout outn|vdd 6.250695e-12
* device instance $120 r0 *1 512.25,-46.25 cap_cmim
C$120 xout outn|vdd 6.250695e-12
* device instance $121 r0 *1 578.75,-46.25 cap_cmim
C$121 xout outn|vdd 6.250695e-12
* device instance $122 r0 *1 645.25,-46.25 cap_cmim
C$122 xout outn|vdd 6.250695e-12
* device instance $123 r0 *1 711.75,-46.25 cap_cmim
C$123 xout outn|vdd 6.250695e-12
* device instance $124 r0 *1 -160,-202.175 rppd
X$124 xout e1|vss e1|vss rppd r=99999.4234592 L=386.65U W=1U
* device instance $125 r0 *1 -12.503,-1.14 rppd
X$125 bref b1 e1|vss rppd r=329.741550696 L=1.005U W=1U
* device instance $126 r0 *1 -857.7,100.5 rppd
X$126 vb2 outn|vdd e1|vss rppd r=1000.41749503 L=3.6U W=1U
* device instance $127 r0 *1 -824.755,100.5 rppd
X$127 e1|vss vb2 e1|vss rppd r=10999.8210736 L=42.29U W=1U
* device instance $128 r0 *1 -787.168,100.5 rppd
X$128 e1|vss nce e1|vss rppd r=3400.11928429 L=12.885U W=1U
* device instance $129 r0 *1 -735.263,100.5 rppd
X$129 cb3 vbg e1|vss rppd r=18400.5168986 L=70.925U W=1U
* device instance $130 r0 *1 -671.498,100.5 rppd
X$130 e1|vss es e1|vss rppd r=9530.53677932 L=36.605U W=1U
* device instance $131 r0 *1 -593.03,100.5 rppd
X$131 e1|vss vl e1|vss rppd r=26000.2186879 L=100.33U W=1U
* device instance $132 r0 *1 -521.895,149.922 rhigh
X$132 nca outn|vdd e1|vss rhigh r=10049005.2174 L=3398.82U W=0.5U
.ENDS lna_core
