* lna_core LVS reference -- GENERATED by layout/lvs_reference.py; do not edit.
* source: design/netlist/lna.spice sha256:2575cbbc00459b60cbe05704f240f1c742880286444d01bd2053ddc081b731ae
* scope:  lna_core/realization.json (in_scope: XQ1, XQ2, XQ3, R3b, Cbref, XMis)
* Plain-element form, klt sg13g2 extraction-deck classes. Values are the
* schematic's own; drawn geometry (rppd L/W) is the realization's.
QQ2 outn vb2 casc vss npn13G2 NE=8
QQ1 casc b1 e1 vss npn13G2 NE=8
MMis bref gsvo vdd vdd pfet L=1U W=512U
RR3b bref b1 330 rppd L=1.005U W=1U
QQ3 bref bref vss vss npn13G2 NE=1
CCbref bref vss 100P cap_cmim
.END
