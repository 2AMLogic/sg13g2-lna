* lna_core LVS reference -- GENERATED by layout/lvs_reference.py; do not edit.
* source: design/netlist/lna.spice sha256:151aec66ade8f05257795721527b580014edda14793bdafb2a0816d1a212ec64
* scope:  lna_core/realization.json (in_scope: XQ1, XQ2, XQ3, R3b, Rbleed, Cbref, XMis, Le, Lc, Lb, Cin, Cout, Cpin, Cpout, Csout, XMb, XQb, Rp, XMa, XQa, Rseed, XMv, Rsum, XQc, XMnp1, XMnp2, Rtail, XMld, XMlm, XMref, Rl, R2a, R2b, Cbyp2, Cvdd)
* modeled_in_device (no card): Rle, Rlc, Rlb
* Plain-element form, klt sg13g2 extraction-deck classes. Values are the
* schematic's own; drawn geometry (rppd L/W) is the realization's.
QQ2 outn vb2 casc vss npn13G2 NE=8
QQ1 casc b1 e1 vss npn13G2 NE=8
CCin xin b1 100P cap_cmim
CCout outn xout 100P cap_cmim
CCpin xin vss 0.625995P cap_cmim
CCpout xout vss 0.504268P cap_cmim
CCsout rfout xout 0.346489P cap_cmim
RRbleed xout vss 100k rppd L=386.650U W=1U
CCbyp2 vb2 vss 100P cap_cmim
CCvdd vdd vss 100P cap_cmim
RR2a vdd vb2 1k rppd L=3.6U W=1U
RR2b vb2 vss 11k rppd L=42.29U W=1U
MMb nc_b nc_b vdd vdd pfet L=1U W=10U
QQb nc_b nc_a nc_e vss npn13G2 NE=8
RRp nc_e vss 3.4k rppd L=12.885U W=1U
MMa nc_a nc_b vdd vdd pfet L=1U W=10U
QQa nc_a nc_a vss vss npn13G2 NE=1
RRseed vdd nc_a 10meg rhigh L=98.82U W=0.5U
MMv vbg nc_b vdd vdd pfet L=1U W=10U
RRsum vbg cb3 18.4k rppd L=70.925U W=1U
QQc cb3 cb3 vss vss npn13G2 NE=1
MMnp1 gsvo vbg es vss nfet L=1U W=10U
MMnp2 dn vl es vss nfet L=1U W=10U
RRtail es vss 9.53k rppd L=36.605U W=1U
MMld dn dn vdd vdd pfet L=1U W=10U
MMlm gsvo dn vdd vdd pfet L=1U W=10U
MMref vl gsvo vdd vdd pfet L=1U W=40U
RRl vl vss 26k rppd L=100.33U W=1U
MMis bref gsvo vdd vdd pfet L=1U W=512U
RR3b bref b1 330 rppd L=1.005U W=1U
QQ3 bref bref vss vss npn13G2 NE=1
CCbref bref vss 100P cap_cmim
.END
