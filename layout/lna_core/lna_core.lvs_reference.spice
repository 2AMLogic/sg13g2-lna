* lna_core LVS reference -- GENERATED by layout/lvs_reference.py; do not edit.
* source: design/netlist/lna.spice sha256:151aec66ade8f05257795721527b580014edda14793bdafb2a0816d1a212ec64
* scope:  lna_core/realization.json (in_scope: XQ1, XQ2, XQ3, R3b, Rbleed, Cbref, XMis, Le, Lc, Lb, Cin, Cout, Cpin, Cpout, Csout)
* modeled_in_device (no card): Rle, Rlc, Rlb
* Plain-element form, klt sg13g2 extraction-deck classes. Values are the
* schematic's own; drawn geometry (rppd L/W) is the realization's.
QQ2 outn vb2 casc vss npn13G2 NE=8
QQ1 casc b1 e1 vss npn13G2 NE=8
CCin xin b1 100P cap_cmim
CCout outn xout 100P cap_cmim
CCpin xin vss 0.625995P cap_cmim
CCpout xout vss 0.504268P cap_cmim
CCsout rfout xout 0.346489P cap_cmim
RRbleed xout vss 100k rppd L=386.650U W=1U
MMis bref gsvo vdd vdd pfet L=1U W=512U
RR3b bref b1 330 rppd L=1.005U W=1U
QQ3 bref bref vss vss npn13G2 NE=1
CCbref bref vss 100P cap_cmim
.END
