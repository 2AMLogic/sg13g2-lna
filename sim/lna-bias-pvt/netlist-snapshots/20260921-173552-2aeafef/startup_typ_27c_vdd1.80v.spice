* sg13g2-lna -- supply-ramp startup / latch check of the Q1 bias generator
* (issue #26 Test Plan edge case).
* Generated from sim/lna-bias-pvt/testbench/tb_lna_startup.spice.tmpl by
* sim/lna-bias-pvt/run_biasop_sweep.sh -- do not edit a generated file.
*
* Generated for: HBT_SECTION=hbt_typ MOS_SECTION=mos_tt
* TEMP=27 C VDD=1.80 V
*
* Stage-2 preamble note (issue #33 / DR-0003): same MOS/OSDI preamble
* the biasop deck now carries (the DUT instantiates sg13_hv_pmos /
* sg13_hv_nmos). The fine initial tran step (1e-9) is the
* sg13g2-bandgap fleet's own documented cure (their closed-loop-startup
* and closed-loop-vref-pvt headers, issues #58/#151) for the ngspice
* "Timestep too small ... trouble with <npn13G2 vbic-instance>" stiff
* boot instant this DR-0003 core's ramp hits at the bcs/125C cell with
* the committed 5e-8 initial step: the startup-precharge desert of the
* now-closing servo loop is numerically stiff, the PWL stimulus shape
* is unchanged, and the settled values agree with the op deck exactly
* (see the record's startup CSV).
*
* The bias generator (an 8:1 density-matched current-mirror reference fed
* by R3a through the diode-connected Q3, coupled to b1 through R3b) is
* deliberately FEEDFORWARD: the reference leg has a direct DC path from vdd
* through R3a, so no degenerate all-zero operating state exists the way a
* PTAT/bandgap startup loop can have one. This deck demonstrates that
* numerically instead of asserting it: VDD ramps 0 V -> target in 1 us (slow
* vs. any circuit pole), holds to 12 us, the runner checks that I_C1's last
* samples agree with each other (settled, not ringing) and match the value
* the op-point bench measured at the same PVT cell (no latch to a different
* stable state). The raw ic1(t) transient is kept as a wrdata artifact.
*
* Startup is exercised at the two extreme PVT cells the issue's Test Plan
* names -- bcs/125 C/VDD=1.98 V and wcs/-40 C/VDD=1.62 V bracket the old
* divider's measured min/max bias -- plus the nominal cell.

.lib "/Users/rwalters/share/pdk/ihp-sg13g2/libs.tech/ngspice/models/cornerHBT.lib" hbt_typ
.lib "/Users/rwalters/share/pdk/ihp-sg13g2/libs.tech/ngspice/models/cornerMOShv.lib" mos_tt
.options temp=27 tnom=27 gmin=1e-10

** sch_path: /Users/rwalters/GitHub/sg13g2-lna/.loom/worktrees/issue-33/design/lna.sch
.subckt lna vdd vss rfin rfout

*.iopin vdd
*.iopin vss
*.iopin rfin
*.iopin rfout
XQ2 outn vb2 casc vss npn13G2 Nx=8
XQ1 casc b1 e1 vss npn13G2 Nx=8
Le e1 vss 1n m=1
Lc vdd outn 5n m=1
Cin rfin b1 100p m=1
Cout outn rfout 100p m=1
Cbyp2 vb2 vss 100p m=1
Cvdd vdd vss 100p m=1
R2a vdd vb2 1k m=1
R2b vb2 vss 11k m=1
XMb nc_b nc_b vdd vdd sg13_hv_pmos w=10u l=1u ng=1 m=1
XQb nc_b nc_a nc_e vss npn13G2 Nx=8
Rp nc_e vss 3.4k m=1
XMa nc_a nc_b vdd vdd sg13_hv_pmos w=10u l=1u ng=1 m=1
XQa nc_a nc_a vss vss npn13G2 Nx=1
Rseed vdd nc_a 10meg m=1
XMv vbg nc_b vdd vdd sg13_hv_pmos w=10u l=1u ng=1 m=1
Rsum vbg cb3 18.4k m=1
XQc cb3 cb3 vss vss npn13G2 Nx=1
XMnp1 gsvo vbg es vss sg13_hv_nmos w=10u l=1u ng=1 m=1
XMnp2 dn vl es vss sg13_hv_nmos w=10u l=1u ng=1 m=1
Rtail es vss 9.53k m=1
XMld dn dn vdd vdd sg13_hv_pmos w=10u l=1u ng=1 m=1
XMlm gsvo dn vdd vdd sg13_hv_pmos w=10u l=1u ng=1 m=1
XMref vl gsvo vdd vdd sg13_hv_pmos w=40u l=1u ng=1 m=1
Rl vl vss 26k m=1
XMis bref gsvo vdd vdd sg13_hv_pmos w=512u l=1u ng=1 m=1
R3b bref b1 330 m=1
XQ3 bref bref vss vss npn13G2 Nx=1
Cbref bref vss 100p m=1
.ends

Vdda vdd 0 pwl(0 0 1e-6 1.80 1.2e-5 1.80)
Vssa vss 0 dc 0
Rtin rfin 0 50
Rtout rfout 0 50
Xdut vdd vss rfin rfout lna

.control
pre_osdi /Users/rwalters/share/pdk/ihp-sg13g2/libs.tech/ngspice/osdi/psp103.osdi
pre_osdi /Users/rwalters/share/pdk/ihp-sg13g2/libs.tech/ngspice/osdi/psp103_nqs.osdi
pre_osdi /Users/rwalters/share/pdk/ihp-sg13g2/libs.tech/ngspice/osdi/mosvar.osdi
save @q.xdut.xq1.qnpn13g2[ic]
tran 1e-9 1.2e-5
let ic1v = @q.xdut.xq1.qnpn13g2[ic]
let n = length(ic1v) - 1
let s1 = ic1v[n]
let s2 = ic1v[n-10]
let s3 = ic1v[n-25]
wrdata /Users/rwalters/GitHub/sg13g2-lna/.loom/worktrees/issue-33/sim/lna-bias-pvt/corners/20260921-173552-2aeafef/startup_typ_27c_vdd1.80v.dat ic1v
echo "STARTUP ic1_end $&s1 ic1_s2 $&s2 ic1_s3 $&s3"
echo "BENCH_COMPLETE"
quit
.endc
.end
