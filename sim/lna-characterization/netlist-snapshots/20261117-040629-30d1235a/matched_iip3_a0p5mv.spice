* sg13g2-lna two-tone IIP3 bench (issue #337): variant=matched amp=0.0005 V peak/tone
* Generated by sim/lna-characterization/lna_variant_campaign.py (gen-iip3) -- do not edit.
* Variant: committed matched DUT (design/netlist/lna.spice, verbatim)
* DUT: design/netlist/lna.spice (matched) sha256 151aec66ade8f05257795721527b580014edda14793bdafb2a0816d1a212ec64, inlined verbatim
*   except the inductor edit(s) marked 'VARIANT EDIT'.
* Bench: the ratified testbench/tb_lna_iip3.spice.tmpl protocol (template unchanged).
*   Tones f1 = 2441406250.0 Hz (bin 640), f2 = 2449035644.53125 Hz (bin 642),
*   spacing 7629394.53125 Hz; IM3 at bins 638/644, IM5 floor sentinels at
*   bins 636/646. FFT: tstep 4e-12 s, N = 65536, rectangular window,
*   df = 1/(N*tstep) = 3814697.265625 Hz, tstart = 1e-06 s discarded.
*   Powers: available source power per tone A^2/(8*Rs); output V_peak^2/(2*RL);
*   IIP3 = Pin + (Pout - PIM3)/2. Port convention: 50 Ohm both ports.
* Bias: VDD per corner via klt sim `alter vdd`; corners/sections per the
*   sibling matched_iip3_*.request.json. Definitions in full: README.md.
.options gmin=1e-10 tnom=27
** sch_path: /home/ubuntu/GitHub/sg13g2-lna/.loom/worktrees/issue-258/design/lna.sch
.subckt lna vdd vss rfin rfout

*.iopin vdd
*.iopin vss
*.iopin rfin
*.iopin rfout
XQ2 outn vb2 casc vss npn13G2 Nx=8
XQ1 casc b1 e1 vss npn13G2 Nx=8
Le e1 vss 1n m=1
Rle e1 vss 153.42 m=1
Lc vdd lc_x 5n m=1
Rlc lc_x outn 7.67098 m=1
Cin xin b1 100p m=1
Cout outn xout 100p m=1
Lb lb_x rfin 4.56374n m=1
Rlb xin lb_x 7.00168 m=1
Cpin xin vss 0.625995p m=1
Cpout xout vss 0.504268p m=1
Csout rfout xout 0.346489p m=1
Rbleed xout vss 100k m=1
Cbyp2 vb2 vss 100p m=1
Cvdd vdd vss 100p m=1
R2a vdd vb2 1k m=1
R2b vb2 vss 11k m=1
XMb nc_b nc_b vdd vdd sg13_hv_pmos w=10u l=1u ng=1 m=1
XQb nc_b nc_a nc_e vss npn13G2 Nx=8
Rp nc_e vss 3.4k m=1
XMa nc_a nc_b vdd vdd sg13_hv_pmos w=10u l=1u ng=1 m=1
XQa nc_a nc_a vss vss npn13G2 Nx=1
Rseed vdd nc_a 10meg m=1
XMv vbg nc_b vdd vdd sg13_hv_pmos w=10u l=1u ng=1 m=1
Rsum vbg cb3 18.4k m=1
XQc cb3 cb3 vss vss npn13G2 Nx=1
XMnp1 gsvo vbg es vss sg13_hv_nmos w=10u l=1u ng=1 m=1
XMnp2 dn vl es vss sg13_hv_nmos w=10u l=1u ng=1 m=1
Rtail es vss 9.53k m=1
XMld dn dn vdd vdd sg13_hv_pmos w=10u l=1u ng=1 m=1
XMlm gsvo dn vdd vdd sg13_hv_pmos w=10u l=1u ng=1 m=1
XMref vl gsvo vdd vdd sg13_hv_pmos w=40u l=1u ng=1 m=1
Rl vl vss 26k m=1
XMis bref gsvo vdd vdd sg13_hv_pmos w=512u l=1u ng=1 m=1
R3b bref b1 330 m=1
XQ3 bref bref vss vss npn13G2 Nx=1
Cbref bref vss 100p m=1
.ends
Vdd vdd 0 dc 1.8
* Two tone generators in series form the Thevenin source; Rs = 50 Ohm.
Vt1 vin va dc 0 sin(0 0.0005 2441406250.0 0 0 0)
Vt2 va 0 dc 0 sin(0 0.0005 2449035644.53125 0 0 0)
Rs vin rfin 50
RL rfout 0 50
Xa vdd 0 rfin rfout lna
