* issue #27 |S22|>1 anomaly probe -- probe_lossless_bcs_125C_1p98V
* Fine-resolution low-band stability/match sweep at the worst pre-match DUT cells.
* DUT: design/netlist/lna.spice sha256
*   151aec66ade8f05257795721527b580014edda14793bdafb2a0816d1a212ec64
* inlined VERBATIM below (klt `**.` netlist escapes stripped; probe edits, if
* any, are marked inline and touch ONLY the inductor-loss resistors Rle/Rlc/Rlb).
* Bench: port sources, gmin/tnom options, mu/k expressions and the 50 Ohm port
* convention are identical to the sp_stab bench of sim/lna-characterization
* (netlist-snapshots/20261116-023212-eacd53a/matched_sp_stab.*); the sweep is
* dec 4000 1e7 3e9 -- 100x the committed bench's point density -- over the
* 10 MHz..3 GHz region where every recorded |S22|/mu anomaly lives (188-600 MHz).
* LOCAL single-corner debug probe on the sweep host (ngspice-47, same build as
* the Spot fleet runner; PDK ihp-sg13g2 0.3.0 at /home/ubuntu/share/pdk).
* NOT a PVT campaign; not generated by lna_variant_campaign.py.
.options gmin=1e-10 tnom=27
.lib /home/ubuntu/share/pdk/ihp-sg13g2/libs.tech/ngspice/models/cornerHBT.lib hbt_bcs
.lib /home/ubuntu/share/pdk/ihp-sg13g2/libs.tech/ngspice/models/cornerMOShv.lib mos_ff
.temp 125
.subckt lna vdd vss rfin rfout

*.iopin vdd
*.iopin vss
*.iopin rfin
*.iopin rfout
XQ2 outn vb2 casc vss npn13G2 Nx=8
XQ1 casc b1 e1 vss npn13G2 Nx=8
Le e1 vss 1n m=1
* PROBE EDIT (lossless variant): Rle deleted
Lc vdd lc_x 5n m=1
* PROBE EDIT (lossless variant): Rlc 7.67098 -> 0 (ngspice clamps to 1e-12)
Rlc lc_x outn 0 m=1
Cin xin b1 100p m=1
Cout outn xout 100p m=1
Lb lb_x rfin 4.56374n m=1
* PROBE EDIT (lossless variant): Rlb 7.00168 -> 0 (ngspice clamps to 1e-12)
Rlb xin lb_x 0 m=1
Cpin xin vss 0.625995p m=1
Cpout xout vss 0.504268p m=1
Csout rfout xout 0.346489p m=1
Rbleed xout vss 100k m=1
Cbyp2 vb2 vss 100p m=1
Cvdd vdd vss 100p m=1
R2a vdd vb2 1k m=1
R2b vb2 vss 11k m=1
XMb nc_b nc_b vdd vdd sg13_hv_pmos w=10u l=1u ng=1 m=1
XQb nc_b nc_a nc_e vss npn13G2 Nx=8
Rp nc_e vss 3.4k m=1
XMa nc_a nc_b vdd vdd sg13_hv_pmos w=10u l=1u ng=1 m=1
XQa nc_a nc_a vss vss npn13G2 Nx=1
Rseed vdd nc_a 10meg m=1
XMv vbg nc_b vdd vdd sg13_hv_pmos w=10u l=1u ng=1 m=1
Rsum vbg cb3 18.4k m=1
XQc cb3 cb3 vss vss npn13G2 Nx=1
XMnp1 gsvo vbg es vss sg13_hv_nmos w=10u l=1u ng=1 m=1
XMnp2 dn vl es vss sg13_hv_nmos w=10u l=1u ng=1 m=1
Rtail es vss 9.53k m=1
XMld dn dn vdd vdd sg13_hv_pmos w=10u l=1u ng=1 m=1
XMlm gsvo dn vdd vdd sg13_hv_pmos w=10u l=1u ng=1 m=1
XMref vl gsvo vdd vdd sg13_hv_pmos w=40u l=1u ng=1 m=1
Rl vl vss 26k m=1
XMis bref gsvo vdd vdd sg13_hv_pmos w=512u l=1u ng=1 m=1
R3b bref b1 330 m=1
XQ3 bref bref vss vss npn13G2 Nx=1
Cbref bref vss 100p m=1
.ends
Vdd vdd 0 dc 1.98
Vp1 pin 0 dc 0 ac 1 portnum 1 z0 50
Vp2 pout 0 dc 0 ac 0 portnum 2 z0 50
Xa vdd 0 pin pout lna
.control
pre_osdi /home/ubuntu/share/pdk/ihp-sg13g2/libs.tech/ngspice/osdi/psp103.osdi
pre_osdi /home/ubuntu/share/pdk/ihp-sg13g2/libs.tech/ngspice/osdi/psp103_nqs.osdi
pre_osdi /home/ubuntu/share/pdk/ihp-sg13g2/libs.tech/ngspice/osdi/mosvar.osdi
save all
sp dec 4000 1e7 3e9
let m11 = mag(s_1_1)
let m22 = mag(s_2_2)
let s12s21 = mag(s_1_2*s_2_1)
let delta = s_1_1*s_2_2 - s_1_2*s_2_1
let mu = ((1 - m11^2)/(mag(s_2_2 - conj(s_1_1)*delta) + s12s21))
let k = ((1 - m11^2 - m22^2 + mag(delta)^2)/(2*s12s21))
let n_s22_gt1 = mean(m22 gt 1)*length(m22)
let n_s22_gt1_tol = mean(m22 gt 1.000001)*length(m22)
let n_mu_lt1 = mean(mu lt 1)*length(mu)
let n_k_lt1 = mean(k lt 1)*length(k)
print vecmax(m22) vecmin(mu) vecmin(k) n_s22_gt1 n_s22_gt1_tol n_mu_lt1 n_k_lt1 vecmax(m11)
print frequency[maxindex(m22)] frequency[maxindex(m11)] frequency[minindex(mu)] frequency[minindex(k)]
wrdata probe_lossless_bcs_125C_1p98V.table.txt frequency mu k m11 m22
quit
.endc
.end
