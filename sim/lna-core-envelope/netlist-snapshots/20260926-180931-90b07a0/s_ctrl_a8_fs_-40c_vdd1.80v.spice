* sg13g2-lna -- core-envelope S-parameter / NF / stability bench (issue #52)
*
* Generated from
* sim/lna-core-envelope/testbench/tb_core_envelope.spice.tmpl by
* sim/lna-core-envelope/run_core_envelope.sh -- do not edit a generated
* netlist-snapshots/*.spice file directly, edit this template and re-run the
* sweep. Full methodology, bench definitions and model limitations are in
* sim/lna-core-envelope/README.md.
*
* PROVENANCE. This deck is sim/lna-characterization/testbench/
* tb_lna_sparam.spice.tmpl with TWO deliberate differences and no others:
*
*   1. The DUT subcircuit is a VARIANT of design/netlist/lna.spice, not the
*      committed netlist verbatim. Which variant is recorded in the header
*      line below and in the run record; the variant recipes themselves are
*      generated by the runner from the committed netlist (single-stage
*      variants: emitter geometry + bias-mirror width substitutions only) or
*      from the committed dut/lna_2stage.spice.tmpl (two-stage variants).
*      The unmodified committed netlist runs here too, as the control
*      variant `s_ctrl_a8`, and MUST reproduce record
*      20260926-122301-088c734's numbers -- the runner's own regression
*      check.
*   2. The two-tone IIP3 phase of the lna-characterization bench is absent.
*      This experiment answers a (gain, NF, P_dc) envelope question; IIP3 is
*      not part of it and is not claimed by any number this bench produces.
*
* Everything else -- the 50 Ohm `sp` ports, the `donoise` NF/NFmin, the
* `.noise`-based nf290/nf30015 pair with noiseless Rs/RL, the broadband
* stability sweep, the wrdata column order, `.options gmin=1e-10`, the
* cornerHBT.lib + cornerMOShv.lib preamble and the `pre_osdi` loads -- is
* character-for-character the lna-characterization bench's, so the two
* experiments' numbers are directly comparable.
*
* Generated for: VARIANT=s_ctrl_a8 HBT_SECTION=hbt_typ
* MOS_SECTION=mos_fs TEMP=-40 C VDD=1.80 V

.lib "/home/ubuntu/share/pdk/ihp-sg13g2/libs.tech/ngspice/models/cornerHBT.lib" hbt_typ
.lib "/home/ubuntu/share/pdk/ihp-sg13g2/libs.tech/ngspice/models/cornerMOShv.lib" mos_fs

.options temp=-40 tnom=27 gmin=1e-10

* ---------------------------------------------------------------------
* DUT subcircuit (variant s_ctrl_a8) -- inlined verbatim
* ---------------------------------------------------------------------
** sch_path: /Users/rwalters/GitHub/sg13g2-lna/.loom/worktrees/issue-33/design/lna.sch
.subckt lna vdd vss rfin rfout

*.iopin vdd
*.iopin vss
*.iopin rfin
*.iopin rfout
XQ2 outn vb2 casc vss npn13G2 Nx=8 m=1
XQ1 casc b1 e1 vss npn13G2 Nx=8 m=1
Le e1 vss 1n m=1
Lc vdd outn 5n m=1
Cin rfin b1 100p m=1
Cout outn rfout 100p m=1
Cbyp2 vb2 vss 100p m=1
Cvdd vdd vss 100p m=1
R2a vdd vb2 1k m=1
R2b vb2 vss 11k m=1
XMb nc_b nc_b vdd vdd sg13_hv_pmos w=10u l=1u ng=1 m=1
XQb nc_b nc_a nc_e vss npn13G2 Nx=8
Rp nc_e vss 3.4k m=1
XMa nc_a nc_b vdd vdd sg13_hv_pmos w=10u l=1u ng=1 m=1
XQa nc_a nc_a vss vss npn13G2 Nx=1
Rseed vdd nc_a 10meg m=1
XMv vbg nc_b vdd vdd sg13_hv_pmos w=10u l=1u ng=1 m=1
Rsum vbg cb3 18.4k m=1
XQc cb3 cb3 vss vss npn13G2 Nx=1
XMnp1 gsvo vbg es vss sg13_hv_nmos w=10u l=1u ng=1 m=1
XMnp2 dn vl es vss sg13_hv_nmos w=10u l=1u ng=1 m=1
Rtail es vss 9.53k m=1
XMld dn dn vdd vdd sg13_hv_pmos w=10u l=1u ng=1 m=1
XMlm gsvo dn vdd vdd sg13_hv_pmos w=10u l=1u ng=1 m=1
XMref vl gsvo vdd vdd sg13_hv_pmos w=40u l=1u ng=1 m=1
Rl vl vss 26k m=1
XMis bref gsvo vdd vdd sg13_hv_pmos w=512u l=1u ng=1 m=1
R3b bref b1 330 m=1
XQ3 bref bref vss vss npn13G2 Nx=1
Cbref bref vss 100p m=1
.ends

* --- Xa: S-parameter branch (50 Ohm ports at both ends) ---------------
Vdda vdda 0 dc 1.80
Vp1 pin 0 dc 0 ac 1 portnum 1 z0 50
Vp2 pout 0 dc 0 ac 0 portnum 2 z0 50
Xa vdda 0 pin pout lna

* --- Xb: 50 Ohm Thevenin source / 50 Ohm load, .noise + transducer gain
Vddb vddb 0 dc 1.80
Vin vin 0 dc 0 ac 1
Rs vin nfin 50 noisy=0
RL nfout 0 50 noisy=0
Xb vddb 0 nfin nfout lna

.control
pre_osdi /home/ubuntu/share/pdk/ihp-sg13g2/libs.tech/ngspice/osdi/psp103.osdi
pre_osdi /home/ubuntu/share/pdk/ihp-sg13g2/libs.tech/ngspice/osdi/psp103_nqs.osdi
pre_osdi /home/ubuntu/share/pdk/ihp-sg13g2/libs.tech/ngspice/osdi/mosvar.osdi
* --- DC operating point (the bias point every number below carries) ---
* xq1 / xq2 name the input device of stage 1 and, for a
* two-stage variant, the input device of stage 2 (for a single-stage
* variant Q2_REF is the cascode device, exactly as in the
* lna-characterization bench).
op
let ic1 = @q.xa.xq1.qnpn13g2[ic]
let ic2 = @q.xa.xq2.qnpn13g2[ic]
let ib1 = @q.xa.xq1.qnpn13g2[ib]
let vce1 = v(xa.casc) - v(xa.e1)
let vce2 = v(xa.outn) - v(xa.casc)
let vbe1 = v(xa.b1) - v(xa.e1)
let idd = -i(vdda)
let pdc = 1.80 * (-i(vdda))
echo "OP ic1 $&ic1 ic2 $&ic2 ib1 $&ib1 vce1 $&vce1 vce2 $&vce2 vbe1 $&vbe1 idd $&idd pdc $&pdc"

* --- In-band S-parameters + ngspice's own two-port noise figure -------
sp lin 11 2.4e9 2.4835e9 1
let dlt = s_1_1*s_2_2 - s_1_2*s_2_1
let kfac = (1 - mag(s_1_1)^2 - mag(s_2_2)^2 + mag(dlt)^2)/(2*mag(s_1_2*s_2_1))
let mufac = (1 - mag(s_1_1)^2)/(mag(s_2_2 - conj(s_1_1)*dlt) + mag(s_1_2*s_2_1))
wrdata /home/ubuntu/GitHub/sg13g2-lna/.loom/worktrees/issue-52/sim/lna-core-envelope/corners/20260926-180931-90b07a0/s_ctrl_a8_fs_-40c_vdd1.80v.inband.dat s_1_1 s_2_1 s_1_2 s_2_2 kfac mufac mag(dlt) NF NFmin
echo "INBAND_DAT_WRITTEN /home/ubuntu/GitHub/sg13g2-lna/.loom/worktrees/issue-52/sim/lna-core-envelope/corners/20260926-180931-90b07a0/s_ctrl_a8_fs_-40c_vdd1.80v.inband.dat"

* --- Broadband stability sweep (out-of-band, both directions) ---------
sp dec 40 1e7 3e10
let dltb = s_1_1*s_2_2 - s_1_2*s_2_1
let kfacb = (1 - mag(s_1_1)^2 - mag(s_2_2)^2 + mag(dltb)^2)/(2*mag(s_1_2*s_2_1))
let mufacb = (1 - mag(s_1_1)^2)/(mag(s_2_2 - conj(s_1_1)*dltb) + mag(s_1_2*s_2_1))
wrdata /home/ubuntu/GitHub/sg13g2-lna/.loom/worktrees/issue-52/sim/lna-core-envelope/corners/20260926-180931-90b07a0/s_ctrl_a8_fs_-40c_vdd1.80v.stability.dat kfacb mufacb mag(dltb) mag(s_1_1) mag(s_2_1) mag(s_2_2)
echo "STAB_DAT_WRITTEN /home/ubuntu/GitHub/sg13g2-lna/.loom/worktrees/issue-52/sim/lna-core-envelope/corners/20260926-180931-90b07a0/s_ctrl_a8_fs_-40c_vdd1.80v.stability.dat"

* --- NF at the band bottom / middle / top -----------------------------
* NF_290  : IEEE/Friis convention, source reference temperature T0 = 290 K
*           -- the reference spec/target-spec.md's NF row RATIFIES.
* NF_30015: the same quantity referenced to 300.15 K, kept only for
*           continuity with sim/hbt-characterization/'s older records.
ac lin 1 2.4e9 2.4e9
let g_lo = db(2*v(nfout))
echo "GAIN lo $&g_lo"
noise v(nfout) vin lin 1 2.4e9 2.4e9
let f290 = 1 + (inoise_spectrum^2)/(4*1.380649e-23*290*50)
let f30015 = 1 + (inoise_spectrum^2)/(4*1.380649e-23*300.15*50)
let nf290 = 10*log10(f290)
let nf30015 = 10*log10(f30015)
echo "NF lo $&nf290 $&nf30015"

ac lin 1 2.44175e9 2.44175e9
let g_mid = db(2*v(nfout))
echo "GAIN mid $&g_mid"
noise v(nfout) vin lin 1 2.44175e9 2.44175e9
let f290m = 1 + (inoise_spectrum^2)/(4*1.380649e-23*290*50)
let f30015m = 1 + (inoise_spectrum^2)/(4*1.380649e-23*300.15*50)
let nf290m = 10*log10(f290m)
let nf30015m = 10*log10(f30015m)
echo "NF mid $&nf290m $&nf30015m"

ac lin 1 2.4835e9 2.4835e9
let g_hi = db(2*v(nfout))
echo "GAIN hi $&g_hi"
noise v(nfout) vin lin 1 2.4835e9 2.4835e9
let f290h = 1 + (inoise_spectrum^2)/(4*1.380649e-23*290*50)
let f30015h = 1 + (inoise_spectrum^2)/(4*1.380649e-23*300.15*50)
let nf290h = 10*log10(f290h)
let nf30015h = 10*log10(f30015h)
echo "NF hi $&nf290h $&nf30015h"
echo "BENCH_COMPLETE"
.endc
.end
