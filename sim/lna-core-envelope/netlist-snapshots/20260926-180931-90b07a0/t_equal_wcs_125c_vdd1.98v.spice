* sg13g2-lna -- core-envelope S-parameter / NF / stability bench (issue #52)
*
* Generated from
* sim/lna-core-envelope/testbench/tb_core_envelope.spice.tmpl by
* sim/lna-core-envelope/run_core_envelope.sh -- do not edit a generated
* netlist-snapshots/*.spice file directly, edit this template and re-run the
* sweep. Full methodology, bench definitions and model limitations are in
* sim/lna-core-envelope/README.md.
*
* PROVENANCE. This deck is sim/lna-characterization/testbench/
* tb_lna_sparam.spice.tmpl with TWO deliberate differences and no others:
*
*   1. The DUT subcircuit is a VARIANT of design/netlist/lna.spice, not the
*      committed netlist verbatim. Which variant is recorded in the header
*      line below and in the run record; the variant recipes themselves are
*      generated by the runner from the committed netlist (single-stage
*      variants: emitter geometry + bias-mirror width substitutions only) or
*      from the committed dut/lna_2stage.spice.tmpl (two-stage variants).
*      The unmodified committed netlist runs here too, as the control
*      variant `s_ctrl_a8`, and MUST reproduce record
*      20260926-122301-088c734's numbers -- the runner's own regression
*      check.
*   2. The two-tone IIP3 phase of the lna-characterization bench is absent.
*      This experiment answers a (gain, NF, P_dc) envelope question; IIP3 is
*      not part of it and is not claimed by any number this bench produces.
*
* Everything else -- the 50 Ohm `sp` ports, the `donoise` NF/NFmin, the
* `.noise`-based nf290/nf30015 pair with noiseless Rs/RL, the broadband
* stability sweep, the wrdata column order, `.options gmin=1e-10`, the
* cornerHBT.lib + cornerMOShv.lib preamble and the `pre_osdi` loads -- is
* character-for-character the lna-characterization bench's, so the two
* experiments' numbers are directly comparable.
*
* Generated for: VARIANT=t_equal HBT_SECTION=hbt_wcs
* MOS_SECTION=mos_ss TEMP=125 C VDD=1.98 V

.lib "/home/ubuntu/share/pdk/ihp-sg13g2/libs.tech/ngspice/models/cornerHBT.lib" hbt_wcs
.lib "/home/ubuntu/share/pdk/ihp-sg13g2/libs.tech/ngspice/models/cornerMOShv.lib" mos_ss

.options temp=125 tnom=27 gmin=1e-10

* ---------------------------------------------------------------------
* DUT subcircuit (variant t_equal) -- inlined verbatim
* ---------------------------------------------------------------------
* sg13g2-lna -- TWO-STAGE PROBE DUT (issue #52), NOT a committed design.
*
* This file exists to answer one acceptance-criterion question of issue #52
* with a simulated result rather than an argument: *can a device-count /
* topology change close the RATIFIED Gain (S21) > 15 dB row inside the
* RATIFIED P_dc < 10 mW row?* It is a PROBE, in the same sense
* sim/biasref-topology/'s Phase-A/B skeletons were probes: it is not
* `design/lna.sch`, it is not netlisted from any schematic, and nothing in
* `design/` changes because of it. `design/netlist/lna.spice` remains the
* committed DUT and the subject of every conformance number in this repo.
*
* Construction, stated so a reader can audit it against the committed
* netlist line by line:
*
*   - The DR-0003 flat bias-reference core (XMb/XQb/Rp/XMa/XQa/Rseed/XMv/
*     Rsum/XQc/XMnp1/XMnp2/Rtail/XMld/XMlm/XMref/Rl/XMis/XQ3/Cbref) is
*     copied VERBATIM from design/netlist/lna.spice with exactly one
*     substitution: XMis's width, which is the knob that sets the island
*     reference current and therefore the total DC power. One core feeds
*     BOTH stages (the two-stage variant does not pay the bias overhead
*     twice) through its own 330 Ohm series base resistor per stage
*     (R3ba/R3bb), each identical to the committed R3b.
*   - The cascode base divider (R2a 1k / R2b 11k / Cbyp2 / Cvdd) is copied
*     verbatim and shared by both stages, as in the committed core.
*   - Each RF stage is the committed cascode verbatim -- XQ1/XQ2 npn13G2,
*     Le = 1 nH emitter degeneration, Lc = 5 nH collector inductor -- with
*     the emitter geometry (Nx, m) substituted per stage.
*   - The interstage connection is one 100 pF ideal DC block (Cc), the same
*     primitive and value the committed Cin/Cout use. There is NO
*     interstage matching network: that would be design work, and #27 owns
*     the matching networks. The consequence is stated rather than hidden
*     -- the interstage transfer here is an unmatched 5 nH tank driving the
*     next base, so the two-stage gain numbers this probe reports are what
*     the topology gives with no interstage design at all.
*
* Ideal-passive limitation: Le/Lc/Cc are ideal infinite-Q SPICE primitives,
* exactly as in the committed netlist, because SG13G2 ships no simulatable
* inductor model (issue #5, upstream 2AMLogic/klayout-tools#1519). Every
* gain number from this DUT is therefore the MOST OPTIMISTIC case and every
* stability number the LEAST-DAMPED case -- the same caveat the
* lna-characterization record carries, and the reason this probe's gain
* claim is stated as an envelope bound, not as a design result.
*
* Substituted by sim/lna-core-envelope/run_core_envelope.sh:
*   8/1  stage-1 emitter multiplicity / instance multiplicity
*   8/1  stage-2 emitter multiplicity / instance multiplicity
*   273         XMis width in um (the total-power knob)

.subckt lna vdd vss rfin rfout
* --- RF stage 1 (cascode) --------------------------------------------
XQ2a outa vb2 casca vss npn13G2 Nx=8 m=1
XQ1a casca b1a e1a vss npn13G2 Nx=8 m=1
Lea e1a vss 1n m=1
Lca vdd outa 5n m=1
Cin rfin b1a 100p m=1
* --- interstage DC block (no interstage match -- see header) ----------
Cc outa b1b 100p m=1
* --- RF stage 2 (cascode) --------------------------------------------
XQ2b outb vb2 cascb vss npn13G2 Nx=8 m=1
XQ1b cascb b1b e1b vss npn13G2 Nx=8 m=1
Leb e1b vss 1n m=1
Lcb vdd outb 5n m=1
Cout outb rfout 100p m=1
* --- shared cascode base divider (verbatim from the committed core) ---
Cbyp2 vb2 vss 100p m=1
Cvdd vdd vss 100p m=1
R2a vdd vb2 1k m=1
R2b vb2 vss 11k m=1
* --- DR-0003 flat bias reference core (verbatim except XMis width) ----
XMb nc_b nc_b vdd vdd sg13_hv_pmos w=10u l=1u ng=1 m=1
XQb nc_b nc_a nc_e vss npn13G2 Nx=8
Rp nc_e vss 3.4k m=1
XMa nc_a nc_b vdd vdd sg13_hv_pmos w=10u l=1u ng=1 m=1
XQa nc_a nc_a vss vss npn13G2 Nx=1
Rseed vdd nc_a 10meg m=1
XMv vbg nc_b vdd vdd sg13_hv_pmos w=10u l=1u ng=1 m=1
Rsum vbg cb3 18.4k m=1
XQc cb3 cb3 vss vss npn13G2 Nx=1
XMnp1 gsvo vbg es vss sg13_hv_nmos w=10u l=1u ng=1 m=1
XMnp2 dn vl es vss sg13_hv_nmos w=10u l=1u ng=1 m=1
Rtail es vss 9.53k m=1
XMld dn dn vdd vdd sg13_hv_pmos w=10u l=1u ng=1 m=1
XMlm gsvo dn vdd vdd sg13_hv_pmos w=10u l=1u ng=1 m=1
XMref vl gsvo vdd vdd sg13_hv_pmos w=40u l=1u ng=1 m=1
Rl vl vss 26k m=1
XMis bref gsvo vdd vdd sg13_hv_pmos w=273u l=1u ng=1 m=1
R3ba bref b1a 330 m=1
R3bb bref b1b 330 m=1
XQ3 bref bref vss vss npn13G2 Nx=1
Cbref bref vss 100p m=1
.ends

* --- Xa: S-parameter branch (50 Ohm ports at both ends) ---------------
Vdda vdda 0 dc 1.98
Vp1 pin 0 dc 0 ac 1 portnum 1 z0 50
Vp2 pout 0 dc 0 ac 0 portnum 2 z0 50
Xa vdda 0 pin pout lna

* --- Xb: 50 Ohm Thevenin source / 50 Ohm load, .noise + transducer gain
Vddb vddb 0 dc 1.98
Vin vin 0 dc 0 ac 1
Rs vin nfin 50 noisy=0
RL nfout 0 50 noisy=0
Xb vddb 0 nfin nfout lna

.control
pre_osdi /home/ubuntu/share/pdk/ihp-sg13g2/libs.tech/ngspice/osdi/psp103.osdi
pre_osdi /home/ubuntu/share/pdk/ihp-sg13g2/libs.tech/ngspice/osdi/psp103_nqs.osdi
pre_osdi /home/ubuntu/share/pdk/ihp-sg13g2/libs.tech/ngspice/osdi/mosvar.osdi
* --- DC operating point (the bias point every number below carries) ---
* xq1a / xq1b name the input device of stage 1 and, for a
* two-stage variant, the input device of stage 2 (for a single-stage
* variant Q2_REF is the cascode device, exactly as in the
* lna-characterization bench).
op
let ic1 = @q.xa.xq1a.qnpn13g2[ic]
let ic2 = @q.xa.xq1b.qnpn13g2[ic]
let ib1 = @q.xa.xq1a.qnpn13g2[ib]
let vce1 = v(xa.casca) - v(xa.e1a)
let vce2 = v(xa.outa) - v(xa.casca)
let vbe1 = v(xa.b1a) - v(xa.e1a)
let idd = -i(vdda)
let pdc = 1.98 * (-i(vdda))
echo "OP ic1 $&ic1 ic2 $&ic2 ib1 $&ib1 vce1 $&vce1 vce2 $&vce2 vbe1 $&vbe1 idd $&idd pdc $&pdc"

* --- In-band S-parameters + ngspice's own two-port noise figure -------
sp lin 11 2.4e9 2.4835e9 1
let dlt = s_1_1*s_2_2 - s_1_2*s_2_1
let kfac = (1 - mag(s_1_1)^2 - mag(s_2_2)^2 + mag(dlt)^2)/(2*mag(s_1_2*s_2_1))
let mufac = (1 - mag(s_1_1)^2)/(mag(s_2_2 - conj(s_1_1)*dlt) + mag(s_1_2*s_2_1))
wrdata /home/ubuntu/GitHub/sg13g2-lna/.loom/worktrees/issue-52/sim/lna-core-envelope/corners/20260926-180931-90b07a0/t_equal_wcs_125c_vdd1.98v.inband.dat s_1_1 s_2_1 s_1_2 s_2_2 kfac mufac mag(dlt) NF NFmin
echo "INBAND_DAT_WRITTEN /home/ubuntu/GitHub/sg13g2-lna/.loom/worktrees/issue-52/sim/lna-core-envelope/corners/20260926-180931-90b07a0/t_equal_wcs_125c_vdd1.98v.inband.dat"

* --- Broadband stability sweep (out-of-band, both directions) ---------
sp dec 40 1e7 3e10
let dltb = s_1_1*s_2_2 - s_1_2*s_2_1
let kfacb = (1 - mag(s_1_1)^2 - mag(s_2_2)^2 + mag(dltb)^2)/(2*mag(s_1_2*s_2_1))
let mufacb = (1 - mag(s_1_1)^2)/(mag(s_2_2 - conj(s_1_1)*dltb) + mag(s_1_2*s_2_1))
wrdata /home/ubuntu/GitHub/sg13g2-lna/.loom/worktrees/issue-52/sim/lna-core-envelope/corners/20260926-180931-90b07a0/t_equal_wcs_125c_vdd1.98v.stability.dat kfacb mufacb mag(dltb) mag(s_1_1) mag(s_2_1) mag(s_2_2)
echo "STAB_DAT_WRITTEN /home/ubuntu/GitHub/sg13g2-lna/.loom/worktrees/issue-52/sim/lna-core-envelope/corners/20260926-180931-90b07a0/t_equal_wcs_125c_vdd1.98v.stability.dat"

* --- NF at the band bottom / middle / top -----------------------------
* NF_290  : IEEE/Friis convention, source reference temperature T0 = 290 K
*           -- the reference spec/target-spec.md's NF row RATIFIES.
* NF_30015: the same quantity referenced to 300.15 K, kept only for
*           continuity with sim/hbt-characterization/'s older records.
ac lin 1 2.4e9 2.4e9
let g_lo = db(2*v(nfout))
echo "GAIN lo $&g_lo"
noise v(nfout) vin lin 1 2.4e9 2.4e9
let f290 = 1 + (inoise_spectrum^2)/(4*1.380649e-23*290*50)
let f30015 = 1 + (inoise_spectrum^2)/(4*1.380649e-23*300.15*50)
let nf290 = 10*log10(f290)
let nf30015 = 10*log10(f30015)
echo "NF lo $&nf290 $&nf30015"

ac lin 1 2.44175e9 2.44175e9
let g_mid = db(2*v(nfout))
echo "GAIN mid $&g_mid"
noise v(nfout) vin lin 1 2.44175e9 2.44175e9
let f290m = 1 + (inoise_spectrum^2)/(4*1.380649e-23*290*50)
let f30015m = 1 + (inoise_spectrum^2)/(4*1.380649e-23*300.15*50)
let nf290m = 10*log10(f290m)
let nf30015m = 10*log10(f30015m)
echo "NF mid $&nf290m $&nf30015m"

ac lin 1 2.4835e9 2.4835e9
let g_hi = db(2*v(nfout))
echo "GAIN hi $&g_hi"
noise v(nfout) vin lin 1 2.4835e9 2.4835e9
let f290h = 1 + (inoise_spectrum^2)/(4*1.380649e-23*290*50)
let f30015h = 1 + (inoise_spectrum^2)/(4*1.380649e-23*300.15*50)
let nf290h = 10*log10(f290h)
let nf30015h = 10*log10(f30015h)
echo "NF hi $&nf290h $&nf30015h"
echo "BENCH_COMPLETE"
.endc
.end
