* sg13g2-lna core-envelope campaign bench (issue #58): case=gate__s_fixi_a80__ideal analysis=noise
* Generated by sim/lna-core-envelope/core_envelope_campaign.py (gen) -- do not edit.
* Sizing: s_fixi_a80 -- larger emitter array: RF cascode pair Nx=10 m=8, XMis w=51.2u
* Loss basis: ideal -- ideal Le and Lc (as committed)
* Divider: committed R2a/R2b = 1k/11k
* DUT: design/netlist/lna.spice sha256 23f9445b01dbec997a2247e40deb6fcaf09b4c2a4a3301c0aae2d37ad27768d1, inlined verbatim
*   except the edits marked 'VARIANT EDIT'. design/ is not modified.
* Port convention: 50 Ohm at both ports; VDD per corner via klt sim `alter vdd`.
* op: DC operating point only. sp_band/sp_stab: sp with portnum/z0 sources.
*   noise: 50 Ohm Thevenin source, noiseless Rs/RL, NF re-referenced to T0 = 290 K.
* Analysis, corners, model sections: see the sibling <case>__<analysis>.request.json.
* Bench definitions in full: sim/lna-core-envelope/README.md.
.options gmin=1e-10 tnom=27
** sch_path: /Users/rwalters/GitHub/sg13g2-lna/.loom/worktrees/issue-33/design/lna.sch
.subckt lna vdd vss rfin rfout

*.iopin vdd
*.iopin vss
*.iopin rfin
*.iopin rfout
* VARIANT EDIT (sizing s_fixi_a80): was 'XQ2 outn vb2 casc vss npn13G2 Nx=8'
XQ2 outn vb2 casc vss npn13G2 Nx=10 m=8
* VARIANT EDIT (sizing s_fixi_a80): was 'XQ1 casc b1 e1 vss npn13G2 Nx=8'
XQ1 casc b1 e1 vss npn13G2 Nx=10 m=8
Le e1 vss 1n m=1
Lc vdd outn 5n m=1
Cin rfin b1 100p m=1
Cout outn rfout 100p m=1
Cbyp2 vb2 vss 100p m=1
Cvdd vdd vss 100p m=1
R2a vdd vb2 1k m=1
R2b vb2 vss 11k m=1
XMb nc_b nc_b vdd vdd sg13_hv_pmos w=10u l=1u ng=1 m=1
XQb nc_b nc_a nc_e vss npn13G2 Nx=8
Rp nc_e vss 3.4k m=1
XMa nc_a nc_b vdd vdd sg13_hv_pmos w=10u l=1u ng=1 m=1
XQa nc_a nc_a vss vss npn13G2 Nx=1
Rseed vdd nc_a 10meg m=1
XMv vbg nc_b vdd vdd sg13_hv_pmos w=10u l=1u ng=1 m=1
Rsum vbg cb3 18.4k m=1
XQc cb3 cb3 vss vss npn13G2 Nx=1
XMnp1 gsvo vbg es vss sg13_hv_nmos w=10u l=1u ng=1 m=1
XMnp2 dn vl es vss sg13_hv_nmos w=10u l=1u ng=1 m=1
Rtail es vss 9.53k m=1
XMld dn dn vdd vdd sg13_hv_pmos w=10u l=1u ng=1 m=1
XMlm gsvo dn vdd vdd sg13_hv_pmos w=10u l=1u ng=1 m=1
XMref vl gsvo vdd vdd sg13_hv_pmos w=40u l=1u ng=1 m=1
Rl vl vss 26k m=1
* VARIANT EDIT (sizing s_fixi_a80): was 'XMis bref gsvo vdd vdd sg13_hv_pmos w=512u l=1u ng=1 m=1'
XMis bref gsvo vdd vdd sg13_hv_pmos w=51.2u l=1u ng=1 m=1
R3b bref b1 330 m=1
XQ3 bref bref vss vss npn13G2 Nx=1
Cbref bref vss 100p m=1
.ends

Vdd vdd 0 dc 1.8
Vin vin 0 dc 0 ac 1
Rs vin nfin 50 noisy=0
RL nfout 0 50 noisy=0
Xb vdd 0 nfin nfout lna
