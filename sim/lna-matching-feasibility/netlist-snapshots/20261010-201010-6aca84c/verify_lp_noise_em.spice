* sg13g2-lna -- matching-network feasibility study, VERIFICATION deck
* (issue #186). Generated from
* sim/lna-matching-feasibility/testbench/tb_match_verify.spice.tmpl by
* sim/lna-matching-feasibility/matching_solver.py (solve) -- do not edit a
* generated netlist-snapshots/*.spice file, edit this template and re-run.
* Full bench definitions: sim/lna-matching-feasibility/README.md.
*
* Candidate: lp_noise   Q case: em
* input: series Lb + shunt Cp at rfin (low-pass L), lowest-F source impedance with |S11(f_mid)| <= -12 dB; output: Lc tank + shunt C at rfout + series C
* Q case: Lc = EM-extracted spiral (fixed geometry, sim/models/sg13g2_inductor_em.spice); Le and the input matching inductor at Q = 10
* Target source impedance at 2.44175 GHz: 140.0567 -20.3214j Ohm
*
* ONE PVT cell only: HBT_SECTION=hbt_typ MOS_SECTION=mos_tt TEMP=27 C
* VDD=1.80 V (the nominal cell). Single-corner exploration, NOT a PVT
* result and not a conformance claim against any spec/target-spec.md row.
*
* Bench (identical to sim/lna-characterization's sp/NF/stability bench,
* restated here so the numbers cannot be separated from it):
*   - S-parameters: ngspice `sp` port sources, portnum/z0 = 50 Ohm at both
*     ports; in-band `sp lin 11 2.4e+09 2.4835e+09 1` (donoise flag
*     set: ngspice two-port NF/NFmin, ANALYSIS-temperature referenced).
*   - Stability: `sp dec 40 1e+07 3e+10`, mu
*     (Edwards-Sinsky), Rollett k, |Delta|, |S11|, |S22| per frequency.
*   - NF at T0 = 290 K: second, isolated copy Xb with its own VDD, 50 Ohm
*     Thevenin source Rs and 50 Ohm load RL both noisy=0, the source term
*     re-introduced analytically:
*     NF = 10*log10(1 + inoise_spectrum^2/(4*k*290*50)),
*     `noise v(nfout) vin lin 21 2.4e+09 2.4835e+09` (sampled maximum,
*     not a continuous-band bound). Internal resistors (the inductor loss
*     resistors included) are noisy at the analysis temperature (300.15 K).
*   - `.options gmin=1e-10` (same override, same reason as
*     sim/lna-characterization/README.md "gmin and the DR-0003 core").
*
* Matched amplifier = subcircuit `lnam`: input network -> DUT -> output
* network. The DUT is design/netlist/lna.spice inlined verbatim except the
* edits marked 'BENCH EDIT' (Le loss resistor; Lc value / loss / EM model
* per the Q case). design/ itself is not modified. Every matching element
* below is external to the DUT and is a generic ideal C or an L with an
* explicit series loss resistor (R = w_mid*L/Q at 2.44175 GHz), or the
* EM-extracted inductor subcircuit where stated.

.lib "/home/ubuntu/share/pdk/ihp-sg13g2/libs.tech/ngspice/models/cornerHBT.lib" hbt_typ
.lib "/home/ubuntu/share/pdk/ihp-sg13g2/libs.tech/ngspice/models/cornerMOShv.lib" mos_tt
.include "/home/ubuntu/GitHub/sg13g2-lna/.loom/worktrees/issue-186/sim/models/sg13g2_inductor_em.spice"

.options temp=27 tnom=27 gmin=1e-10

** sch_path: /Users/rwalters/GitHub/sg13g2-lna/.loom/worktrees/issue-33/design/lna.sch
.subckt lna vdd vss rfin rfout

*.iopin vdd
*.iopin vss
*.iopin rfin
*.iopin rfout
XQ2 outn vb2 casc vss npn13G2 Nx=8
XQ1 casc b1 e1 vss npn13G2 Nx=8
* BENCH EDIT: Le loss as a parallel resistor (R = 153.42 Ohm, DC-transparent)
Le e1 vss 1n m=1
Rle e1 vss 153.42
* BENCH EDIT: Lc = EM-extracted geometry em5 (sim/models/sg13g2_inductor_em.spice)
XLc vdd outn vss inductor w=6.100u s=3.290u d=110.110u nr_r=5 mc_rsh=1.0 mc_rsub=1.0
Cin rfin b1 100p m=1
Cout outn rfout 100p m=1
Cbyp2 vb2 vss 100p m=1
Cvdd vdd vss 100p m=1
R2a vdd vb2 1k m=1
R2b vb2 vss 11k m=1
XMb nc_b nc_b vdd vdd sg13_hv_pmos w=10u l=1u ng=1 m=1
XQb nc_b nc_a nc_e vss npn13G2 Nx=8
Rp nc_e vss 3.4k m=1
XMa nc_a nc_b vdd vdd sg13_hv_pmos w=10u l=1u ng=1 m=1
XQa nc_a nc_a vss vss npn13G2 Nx=1
Rseed vdd nc_a 10meg m=1
XMv vbg nc_b vdd vdd sg13_hv_pmos w=10u l=1u ng=1 m=1
Rsum vbg cb3 18.4k m=1
XQc cb3 cb3 vss vss npn13G2 Nx=1
XMnp1 gsvo vbg es vss sg13_hv_nmos w=10u l=1u ng=1 m=1
XMnp2 dn vl es vss sg13_hv_nmos w=10u l=1u ng=1 m=1
Rtail es vss 9.53k m=1
XMld dn dn vdd vdd sg13_hv_pmos w=10u l=1u ng=1 m=1
XMlm gsvo dn vdd vdd sg13_hv_pmos w=10u l=1u ng=1 m=1
XMref vl gsvo vdd vdd sg13_hv_pmos w=40u l=1u ng=1 m=1
Rl vl vss 26k m=1
XMis bref gsvo vdd vdd sg13_hv_pmos w=512u l=1u ng=1 m=1
R3b bref b1 330 m=1
XQ3 bref bref vss vss npn13G2 Nx=1
Cbref bref vss 100p m=1
.ends

.subckt lnam vdd vss in out
* input network: series Lb = 4.56374 nH (loss R = 7.00168 Ohm), shunt Cp = 0.625995 pF at rfin
Lb in lb_x 4.56374e-09
Rlb lb_x xin 7.00168
Cpin xin vss 6.25995e-13
Xdut vdd vss xin xout lna
* output network: series Cs = 0.357449 pF, shunt Cp = 0.412257 pF at rfout
Cpout xout vss 4.12257e-13
Csout xout out 3.57449e-13
.ends lnam

* --- Xa: S-parameter branch (50 Ohm ports at both ends) -----------------
Vdda vdda 0 dc 1.8
Vp1 pin 0 dc 0 ac 1 portnum 1 z0 50
Vp2 pout 0 dc 0 ac 0 portnum 2 z0 50
Xa vdda 0 pin pout lnam

* --- Xb: 50 Ohm Thevenin source / 50 Ohm load, .noise + transducer gain --
Vddb vddb 0 dc 1.8
Vin vin 0 dc 0 ac 1
Rs vin nfin 50 noisy=0
RL nfout 0 50 noisy=0
Xb vddb 0 nfin nfout lnam

.control
pre_osdi /home/ubuntu/share/pdk/ihp-sg13g2/libs.tech/ngspice/osdi/psp103.osdi
pre_osdi /home/ubuntu/share/pdk/ihp-sg13g2/libs.tech/ngspice/osdi/psp103_nqs.osdi
pre_osdi /home/ubuntu/share/pdk/ihp-sg13g2/libs.tech/ngspice/osdi/mosvar.osdi
set wr_singlescale
set wr_vecnames
option numdgt=10
op
let ic1 = @q.xa.xdut.xq1.qnpn13g2[ic]
let ic2 = @q.xa.xdut.xq2.qnpn13g2[ic]
let idd = -i(vdda)
let pdc = 1.8 * (-i(vdda))
echo "OP ic1 $&ic1 ic2 $&ic2 idd $&idd pdc $&pdc"

* --- in-band S-parameters + ngspice two-port NF ------------------------
sp lin 11 2.4e+09 2.4835e+09 1
wrdata /home/ubuntu/GitHub/sg13g2-lna/.loom/worktrees/issue-186/sim/lna-matching-feasibility/corners/20261010-201010-6aca84c/verify_lp_noise_em.inband.dat real(s_1_1) imag(s_1_1) real(s_2_1) imag(s_2_1) real(s_1_2) imag(s_1_2) real(s_2_2) imag(s_2_2) real(NF) real(NFmin)
echo "DAT_WRITTEN verify_lp_noise_em.inband.dat"

* --- broadband stability ------------------------------------------------
sp dec 40 1e+07 3e+10
wrdata /home/ubuntu/GitHub/sg13g2-lna/.loom/worktrees/issue-186/sim/lna-matching-feasibility/corners/20261010-201010-6aca84c/verify_lp_noise_em.stab.dat real(s_1_1) imag(s_1_1) real(s_2_1) imag(s_2_1) real(s_1_2) imag(s_1_2) real(s_2_2) imag(s_2_2)
echo "DAT_WRITTEN verify_lp_noise_em.stab.dat"

* --- NF at T0 = 290 K over the in-band grid ----------------------------
noise v(nfout) vin lin 21 2.4e+09 2.4835e+09
set lastplot = none
set specplot = none
foreach p $plots
  set specplot = $lastplot
  set lastplot = $p
end
setplot $specplot
let nf290 = 10*log10(1 + (inoise_spectrum^2)/(4*1.380649e-23*290*50))
wrdata /home/ubuntu/GitHub/sg13g2-lna/.loom/worktrees/issue-186/sim/lna-matching-feasibility/corners/20261010-201010-6aca84c/verify_lp_noise_em.nf290.dat nf290
echo "DAT_WRITTEN verify_lp_noise_em.nf290.dat"

* --- transducer-gain cross-check at the band centre --------------------
ac lin 1 2.44175e+09 2.44175e+09
let gt_mid = db(2*v(nfout))
echo "GAIN mid $&gt_mid"
echo "BENCH_COMPLETE"
.endc
.end
