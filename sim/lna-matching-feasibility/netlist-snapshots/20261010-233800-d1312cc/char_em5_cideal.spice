* sg13g2-lna -- matching-network feasibility study, CHARACTERIZATION deck
* (issue #186). Generated from
* sim/lna-matching-feasibility/testbench/tb_match_char.spice.tmpl by
* sim/lna-matching-feasibility/matching_solver.py (gen-char) -- do not edit a
* generated netlist-snapshots/*.spice file, edit this template and re-run.
* Full bench definitions: sim/lna-matching-feasibility/README.md.
*
* ONE PVT cell only: HBT_SECTION=hbt_typ MOS_SECTION=mos_tt TEMP=27 C
* VDD=1.80 V (the nominal cell). This is a single-corner exploration deck,
* not a PVT result.
*
* What it measures (the inputs the matching solver needs), all at 50 Ohm
* `sp` ports (portnum/z0 = 50, the lna-characterization convention):
*
*   A. per Le-loss case (ideal, q20, q10), with the committed Lc = 5 nH:
*      the DUT's in-band two-port S-parameters plus ngspice's two-port noise
*      parameters NFmin, Rn, SOpt (`sp ... 1`, donoise). NFmin is referenced
*      to the ANALYSIS temperature (300.15 K here); the solver re-references
*      to T0 = 290 K.
*   B. per Le-loss case, with Lc replaced by an ideal 1 uH RF choke: S22,
*      from which the solver backs out the device's own collector-node
*      admittance Ydev = Y_node - 1/(jw*1uH) after removing the in-series
*      100 pF Cout. Ydev is what the output network must transform.
*   C. an ideal-Le sweep at the band centre: input impedance and noise
*      parameters versus Le, i.e. how much of a lever degeneration is on
*      this DUT's input.
*   D. the three EM-extracted inductor geometries of
*      sim/models/sg13g2_inductor_em.spice as one-ports (la and sub at
*      ground, lb driven by a 1 A AC current source): Z(f) -> L and Q in band.
*
* DUT: design/netlist/lna.spice inlined verbatim except the edit marked
* 'BENCH EDIT' (a resistor in parallel with Le, so Le's loss can be altered
* without a DC drop; 1e+12 Ohm stands for "ideal"). design/ itself is
* not modified.

.lib "/home/ubuntu/share/pdk/ihp-sg13g2/libs.tech/ngspice/models/cornerHBT.lib" hbt_typ
.lib "/home/ubuntu/share/pdk/ihp-sg13g2/libs.tech/ngspice/models/cornerMOShv.lib" mos_tt
.include "/home/ubuntu/GitHub/sg13g2-lna/.loom/worktrees/issue-193/sim/models/sg13g2_inductor_em.spice"

.options temp=27 tnom=27 gmin=1e-10

** sch_path: /Users/rwalters/GitHub/sg13g2-lna/.loom/worktrees/issue-33/design/lna.sch
.subckt lna vdd vss rfin rfout

*.iopin vdd
*.iopin vss
*.iopin rfin
*.iopin rfout
XQ2 outn vb2 casc vss npn13G2 Nx=8
XQ1 casc b1 e1 vss npn13G2 Nx=8
* BENCH EDIT: Le loss as a parallel resistor (R = 1e+12 Ohm, DC-transparent)
Le e1 vss 1n m=1
Rle e1 vss 1e+12
Lc vdd outn 5n m=1
Cin rfin b1 100p m=1
Cout outn rfout 100p m=1
Cbyp2 vb2 vss 100p m=1
Cvdd vdd vss 100p m=1
R2a vdd vb2 1k m=1
R2b vb2 vss 11k m=1
XMb nc_b nc_b vdd vdd sg13_hv_pmos w=10u l=1u ng=1 m=1
XQb nc_b nc_a nc_e vss npn13G2 Nx=8
Rp nc_e vss 3.4k m=1
XMa nc_a nc_b vdd vdd sg13_hv_pmos w=10u l=1u ng=1 m=1
XQa nc_a nc_a vss vss npn13G2 Nx=1
Rseed vdd nc_a 10meg m=1
XMv vbg nc_b vdd vdd sg13_hv_pmos w=10u l=1u ng=1 m=1
Rsum vbg cb3 18.4k m=1
XQc cb3 cb3 vss vss npn13G2 Nx=1
XMnp1 gsvo vbg es vss sg13_hv_nmos w=10u l=1u ng=1 m=1
XMnp2 dn vl es vss sg13_hv_nmos w=10u l=1u ng=1 m=1
Rtail es vss 9.53k m=1
XMld dn dn vdd vdd sg13_hv_pmos w=10u l=1u ng=1 m=1
XMlm gsvo dn vdd vdd sg13_hv_pmos w=10u l=1u ng=1 m=1
XMref vl gsvo vdd vdd sg13_hv_pmos w=40u l=1u ng=1 m=1
Rl vl vss 26k m=1
XMis bref gsvo vdd vdd sg13_hv_pmos w=512u l=1u ng=1 m=1
* BENCH EDIT (issue #193, variant em5_cideal: finite candidate): EM 5-turn spiral (5.52 nH) in parallel with an ideal tuning C, in series with R3b
R3b bref b1f 330 m=1
XLfeed b1f b1 vss inductor w=6.100u s=3.290u d=110.110u nr_r=5 mc_rsh=1.0 mc_rsub=1.0
Cfeed b1f b1 7.7355948e-13
XQ3 bref bref vss vss npn13G2 Nx=1
Cbref bref vss 100p m=1
.ends

* --- S-parameter branch (50 Ohm ports) -----------------------------------
Vdda vdda 0 dc 1.8
Vp1 pin 0 dc 0 ac 1 portnum 1 z0 50
Vp2 pout 0 dc 0 ac 0 portnum 2 z0 50
Xa vdda 0 pin pout lna

* --- EM inductor one-ports (isolated; la = sub = ground, lb driven) -------
Xem1 0 em1_b 0 inductor w=8.220u s=3.290u d=47.650u nr_r=1 mc_rsh=1.0 mc_rsub=1.0
Iem1 0 em1_b dc 0 ac 1
Xem4 0 em4_b 0 inductor w=8.220u s=3.740u d=141.975u nr_r=4 mc_rsh=1.0 mc_rsub=1.0
Iem4 0 em4_b dc 0 ac 1
Xem5 0 em5_b 0 inductor w=6.100u s=3.290u d=110.110u nr_r=5 mc_rsh=1.0 mc_rsub=1.0
Iem5 0 em5_b dc 0 ac 1

.control
pre_osdi /home/ubuntu/share/pdk/ihp-sg13g2/libs.tech/ngspice/osdi/psp103.osdi
pre_osdi /home/ubuntu/share/pdk/ihp-sg13g2/libs.tech/ngspice/osdi/psp103_nqs.osdi
pre_osdi /home/ubuntu/share/pdk/ihp-sg13g2/libs.tech/ngspice/osdi/mosvar.osdi
set wr_singlescale
set wr_vecnames
option numdgt=10
op
let ic1 = @q.xa.xq1.qnpn13g2[ic]
let ic2 = @q.xa.xq2.qnpn13g2[ic]
let idd = -i(vdda)
echo "OP ic1 $&ic1 ic2 $&ic2 idd $&idd"

* --- A/B. Le-loss case 'ideal' (Rle = 1e+12 Ohm) ---
alter r.xa.rle = 1e+12
alter l.xa.lc = 5e-09
sp lin 11 2.4e+09 2.4835e+09 1
wrdata /home/ubuntu/GitHub/sg13g2-lna/.loom/worktrees/issue-193/sim/lna-matching-feasibility/corners/20261010-233800-d1312cc/charset/em5_cideal/char_ideal_twoport.dat real(s_1_1) imag(s_1_1) real(s_2_1) imag(s_2_1) real(s_1_2) imag(s_1_2) real(s_2_2) imag(s_2_2) real(NF) real(NFmin) real(Rn) real(SOpt) imag(SOpt)
echo "DAT_WRITTEN char_ideal_twoport.dat"
alter l.xa.lc = 1e-06
sp lin 11 2.4e+09 2.4835e+09
wrdata /home/ubuntu/GitHub/sg13g2-lna/.loom/worktrees/issue-193/sim/lna-matching-feasibility/corners/20261010-233800-d1312cc/charset/em5_cideal/char_ideal_choke.dat real(s_2_2) imag(s_2_2) real(s_1_1) imag(s_1_1)
echo "DAT_WRITTEN char_ideal_choke.dat"

* --- A/B. Le-loss case 'q20' (Rle = 306.839 Ohm) ---
alter r.xa.rle = 306.839
alter l.xa.lc = 5e-09
sp lin 11 2.4e+09 2.4835e+09 1
wrdata /home/ubuntu/GitHub/sg13g2-lna/.loom/worktrees/issue-193/sim/lna-matching-feasibility/corners/20261010-233800-d1312cc/charset/em5_cideal/char_q20_twoport.dat real(s_1_1) imag(s_1_1) real(s_2_1) imag(s_2_1) real(s_1_2) imag(s_1_2) real(s_2_2) imag(s_2_2) real(NF) real(NFmin) real(Rn) real(SOpt) imag(SOpt)
echo "DAT_WRITTEN char_q20_twoport.dat"
alter l.xa.lc = 1e-06
sp lin 11 2.4e+09 2.4835e+09
wrdata /home/ubuntu/GitHub/sg13g2-lna/.loom/worktrees/issue-193/sim/lna-matching-feasibility/corners/20261010-233800-d1312cc/charset/em5_cideal/char_q20_choke.dat real(s_2_2) imag(s_2_2) real(s_1_1) imag(s_1_1)
echo "DAT_WRITTEN char_q20_choke.dat"

* --- A/B. Le-loss case 'q10' (Rle = 153.42 Ohm) ---
alter r.xa.rle = 153.42
alter l.xa.lc = 5e-09
sp lin 11 2.4e+09 2.4835e+09 1
wrdata /home/ubuntu/GitHub/sg13g2-lna/.loom/worktrees/issue-193/sim/lna-matching-feasibility/corners/20261010-233800-d1312cc/charset/em5_cideal/char_q10_twoport.dat real(s_1_1) imag(s_1_1) real(s_2_1) imag(s_2_1) real(s_1_2) imag(s_1_2) real(s_2_2) imag(s_2_2) real(NF) real(NFmin) real(Rn) real(SOpt) imag(SOpt)
echo "DAT_WRITTEN char_q10_twoport.dat"
alter l.xa.lc = 1e-06
sp lin 11 2.4e+09 2.4835e+09
wrdata /home/ubuntu/GitHub/sg13g2-lna/.loom/worktrees/issue-193/sim/lna-matching-feasibility/corners/20261010-233800-d1312cc/charset/em5_cideal/char_q10_choke.dat real(s_2_2) imag(s_2_2) real(s_1_1) imag(s_1_1)
echo "DAT_WRITTEN char_q10_choke.dat"

alter r.xa.rle = 1e+12
alter l.xa.lc = 5e-09

* --- C. ideal-Le sweep at the band centre ---
alter l.xa.le = 1e-10
sp lin 1 2.44175e+09 2.44175e+09 1
let zin_r = real(50*(1+s_1_1)/(1-s_1_1))
let zin_i = imag(50*(1+s_1_1)/(1-s_1_1))
let s21m = abs(s_2_1)
let nfmin_r = real(NFmin)
let rn_r = real(Rn)
let gopt_r = real(SOpt)
let gopt_i = imag(SOpt)
echo "LESWEEP 0.1 $&zin_r $&zin_i $&s21m $&nfmin_r $&rn_r $&gopt_r $&gopt_i"
alter l.xa.le = 2e-10
sp lin 1 2.44175e+09 2.44175e+09 1
let zin_r = real(50*(1+s_1_1)/(1-s_1_1))
let zin_i = imag(50*(1+s_1_1)/(1-s_1_1))
let s21m = abs(s_2_1)
let nfmin_r = real(NFmin)
let rn_r = real(Rn)
let gopt_r = real(SOpt)
let gopt_i = imag(SOpt)
echo "LESWEEP 0.2 $&zin_r $&zin_i $&s21m $&nfmin_r $&rn_r $&gopt_r $&gopt_i"
alter l.xa.le = 3e-10
sp lin 1 2.44175e+09 2.44175e+09 1
let zin_r = real(50*(1+s_1_1)/(1-s_1_1))
let zin_i = imag(50*(1+s_1_1)/(1-s_1_1))
let s21m = abs(s_2_1)
let nfmin_r = real(NFmin)
let rn_r = real(Rn)
let gopt_r = real(SOpt)
let gopt_i = imag(SOpt)
echo "LESWEEP 0.3 $&zin_r $&zin_i $&s21m $&nfmin_r $&rn_r $&gopt_r $&gopt_i"
alter l.xa.le = 5e-10
sp lin 1 2.44175e+09 2.44175e+09 1
let zin_r = real(50*(1+s_1_1)/(1-s_1_1))
let zin_i = imag(50*(1+s_1_1)/(1-s_1_1))
let s21m = abs(s_2_1)
let nfmin_r = real(NFmin)
let rn_r = real(Rn)
let gopt_r = real(SOpt)
let gopt_i = imag(SOpt)
echo "LESWEEP 0.5 $&zin_r $&zin_i $&s21m $&nfmin_r $&rn_r $&gopt_r $&gopt_i"
alter l.xa.le = 7e-10
sp lin 1 2.44175e+09 2.44175e+09 1
let zin_r = real(50*(1+s_1_1)/(1-s_1_1))
let zin_i = imag(50*(1+s_1_1)/(1-s_1_1))
let s21m = abs(s_2_1)
let nfmin_r = real(NFmin)
let rn_r = real(Rn)
let gopt_r = real(SOpt)
let gopt_i = imag(SOpt)
echo "LESWEEP 0.7 $&zin_r $&zin_i $&s21m $&nfmin_r $&rn_r $&gopt_r $&gopt_i"
alter l.xa.le = 1e-09
sp lin 1 2.44175e+09 2.44175e+09 1
let zin_r = real(50*(1+s_1_1)/(1-s_1_1))
let zin_i = imag(50*(1+s_1_1)/(1-s_1_1))
let s21m = abs(s_2_1)
let nfmin_r = real(NFmin)
let rn_r = real(Rn)
let gopt_r = real(SOpt)
let gopt_i = imag(SOpt)
echo "LESWEEP 1 $&zin_r $&zin_i $&s21m $&nfmin_r $&rn_r $&gopt_r $&gopt_i"
alter l.xa.le = 1.5e-09
sp lin 1 2.44175e+09 2.44175e+09 1
let zin_r = real(50*(1+s_1_1)/(1-s_1_1))
let zin_i = imag(50*(1+s_1_1)/(1-s_1_1))
let s21m = abs(s_2_1)
let nfmin_r = real(NFmin)
let rn_r = real(Rn)
let gopt_r = real(SOpt)
let gopt_i = imag(SOpt)
echo "LESWEEP 1.5 $&zin_r $&zin_i $&s21m $&nfmin_r $&rn_r $&gopt_r $&gopt_i"
alter l.xa.le = 2e-09
sp lin 1 2.44175e+09 2.44175e+09 1
let zin_r = real(50*(1+s_1_1)/(1-s_1_1))
let zin_i = imag(50*(1+s_1_1)/(1-s_1_1))
let s21m = abs(s_2_1)
let nfmin_r = real(NFmin)
let rn_r = real(Rn)
let gopt_r = real(SOpt)
let gopt_i = imag(SOpt)
echo "LESWEEP 2 $&zin_r $&zin_i $&s21m $&nfmin_r $&rn_r $&gopt_r $&gopt_i"
alter l.xa.le = 3e-09
sp lin 1 2.44175e+09 2.44175e+09 1
let zin_r = real(50*(1+s_1_1)/(1-s_1_1))
let zin_i = imag(50*(1+s_1_1)/(1-s_1_1))
let s21m = abs(s_2_1)
let nfmin_r = real(NFmin)
let rn_r = real(Rn)
let gopt_r = real(SOpt)
let gopt_i = imag(SOpt)
echo "LESWEEP 3 $&zin_r $&zin_i $&s21m $&nfmin_r $&rn_r $&gopt_r $&gopt_i"
alter l.xa.le = 1e-09

* --- D. EM inductor one-ports ---------------------------------------------
ac lin 11 2.4e+09 2.4835e+09
wrdata /home/ubuntu/GitHub/sg13g2-lna/.loom/worktrees/issue-193/sim/lna-matching-feasibility/corners/20261010-233800-d1312cc/charset/em5_cideal/char_em.dat real(v(em1_b)) imag(v(em1_b)) real(v(em4_b)) imag(v(em4_b)) real(v(em5_b)) imag(v(em5_b))
echo "DAT_WRITTEN char_em.dat"
echo "BENCH_COMPLETE"
.endc
.end
